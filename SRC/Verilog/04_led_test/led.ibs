| / 7\'7
| \ \   Xilinx Inc.
| / /
| \_\/.\   IBIS Models for SPARTAN-6
[IBIS ver]   4.2
[File name]   led.ibs
[File Rev]   1.3
[Date]   Sat November 20 20:43:30 2021
[Source]   Derived from spice models, rev0.21, using
   hspice 2007.12
[Notes]   Xilinx IBIS file for SPARTAN-6 I/O standards.
   All models are preliminary.
   The version of IBISCHK used is ibischk4.
   Ibis models were generated using S2IBIS3.
[Disclaimer] The data in this file is derived from SPICE simulations using
                 modeling information extracted from the target process. While
                 a great deal of care has been taken to provide information
                 that is accurate, this model is considered preliminary as it
                 has not been verified by actual silicon measurement. Treat the
                 data in this model as preliminary until actual silicon
                 verification is performed.
[Copyright]   Copyright 2009, 2010, Xilinx Inc., All rights reserved
|   Component SPARTAN-6
[Component]   SPARTAN-6
[Manufacturer]   Xilinx Inc.
[Package]
|FTG256
|variable   typ   min   max
R_pkg   136.91m   67.94m   213.28m
L_pkg   4.77nH   1.92nH   7.93nH
C_pkg   1.11pF   0.64pF   1.62pF
[Pin]  signal_name   model_name
P4   led<0>   LVCMOS33_S_12_TB_25
N5   led<1>   LVCMOS33_S_12_TB_25
P5   led<2>   LVCMOS33_S_12_TB_25
T8   clk   LVCMOS33_S_12_TB_25
M6   led<3>   LVCMOS33_S_12_TB_25
L3   rst_n   LVCMOS33_S_12_LR_25
C4   HSWAPEN   LVCMOS25_S_8_TB_25
A4   IO_L1N_VREF_0   NC
B5   IO_L2P_0   NC
A5   IO_L2N_0   NC
D5   IO_L3P_0   NC
C5   IO_L3N_0   NC
B6   IO_L4P_0   NC
A6   IO_L4N_0   NC
F7   IO_L5P_0   NC
E6   IO_L5N_0   NC
C7   IO_L6P_0   NC
A7   IO_L6N_0   NC
D6   IO_L7P_0   NC
C6   IO_L7N_0   NC
B8   IO_L33P_0   NC
A8   IO_L33N_0   NC
C9   GCLK19   NC
A9   GCLK18   NC
B10   GCLK17   NC
A10   GCLK16   NC
E7   GCLK15   NC
E8   GCLK14   NC
E10   GCLK13   NC
C10   GCLK12   NC
D8   IO_L38P_0   NC
C8   IO_L38N_VREF_0   NC
C11   IO_L39P_0   NC
A11   IO_L39N_0   NC
F9   IO_L40P_0   NC
D9   IO_L40N_0   NC
B12   IO_L62P_0   NC
A12   IO_L62N_VREF_0   NC
C13   SCP7   LVCMOS25_S_8_TB_25
A13   SCP6   LVCMOS25_S_8_TB_25
F10   SCP5   LVCMOS25_S_8_TB_25
E11   SCP4   LVCMOS25_S_8_TB_25
B14   SCP3   LVCMOS25_S_8_TB_25
A14   SCP2   LVCMOS25_S_8_TB_25
D11   SCP1   LVCMOS25_S_8_TB_25
D12   SCP0   LVCMOS25_S_8_TB_25
E13   A25   LVCMOS25_S_8_TB_25
E12   A24   LVCMOS25_S_8_TB_25
B15   A23_M1A13   NC
B16   A22_M1A14   NC
F12   A21_M1RESET   NC
G11   A20_M1A11   NC
D14   A19_M1CKE   NC
D16   A18_M1A12   NC
F13   A17_M1A8   NC
F14   A16_M1A9   NC
C15   A15_M1A10   NC
C16   A14_M1A4   NC
E15   A13_M1WE   NC
E16   A12_M1BA2   NC
F15   A11_M1A7   NC
F16   A10_M1A2   NC
G14   A9_M1BA0   NC
G16   A8_M1BA1   NC
H15   A7_M1A0   NC
H16   A6_M1A1   NC
G12   A5_M1CLK   NC
H11   A4_M1CLKN   NC
H13   M1A3   NC
H14   M1ODT   NC
J11   GCLK11_M1A5   NC
J12   GCLK10_M1A6   NC
J13   GCLK9_IRDY1_M1RASN   NC
K14   GCLK8_M1CASN   NC
K12   GCLK7_M1UDM   NC
K11   GCLK6_TRDY1_M1LDM   NC
J14   GCLK5_M1DQ4   NC
J16   GCLK4_M1DQ5   NC
K15   A3_M1DQ6   NC
K16   A2_M1DQ7   NC
N14   A1_M1LDQS   NC
N16   A0_M1LDQSN   NC
M15   FCS_B_M1DQ2   NC
M16   FOE_B_M1DQ3   NC
L14   FWE_B_M1DQ0   NC
L16   LDC_M1DQ1   NC
P15   HDC_M1DQ8   NC
P16   M1DQ9   NC
R15   M1DQ10   NC
R16   M1DQ11   NC
R14   M1UDQS   NC
T15   M1UDQSN   NC
T14   M1DQ12   NC
T13   M1DQ13   NC
R12   M1DQ14   NC
T12   M1DQ15   NC
L12   IO_L53P_1   NC
L13   IO_L53N_VREF_1   NC
M13   AWAKE   LVCMOS25_S_8_TB_25
M14   DOUT_BUSY   LVCMOS25_S_8_TB_25
R11   CCLK   LVCMOS25_S_8_TB_25
T11   M0_CMPMISO   NC
M12   CMPCLK   NC
M11   CMPMOSI   NC
P10   D0_DIN_MISO_MISO1   LVCMOS25_S_8_TB_25
T10   MOSI_CSI_B_MISO0   LVCMOS25_S_8_TB_25
N12   D1_MISO2   LVCMOS25_S_8_TB_25
P12   D2_MISO3   LVCMOS25_S_8_TB_25
N11   M1   LVCMOS25_S_8_TB_25
P11   D10   LVCMOS25_S_8_TB_25
N9   D11   LVCMOS25_S_8_TB_25
P9   D12   LVCMOS25_S_8_TB_25
R9   IO_L23P_2   NC
T9   IO_L23N_2   NC
L10   IO_L16P_2   NC
M10   IO_L16N_VREF_2   NC
M9   GCLK3   NC
N8   GCLK2   NC
P8   GCLK1_D13   NC
P7   GCLK31_D14   NC
M7   GCLK30_D15   NC
R7   GCLK29   NC
T7   GCLK28   NC
P6   IO_L47P_2   NC
T6   IO_L47N_2   NC
R5   D7   LVCMOS25_S_8_TB_25
T5   RDWR_B   LVCMOS25_S_8_TB_25
L8   D5   LVCMOS25_S_8_TB_25
L7   D6   LVCMOS25_S_8_TB_25
T4   IO_L63N_2   NC
N6   D9   LVCMOS25_S_8_TB_25
R3   INIT_B   LVCMOS25_S_8_TB_25
T3   CSO_B   LVCMOS25_S_8_TB_25
M4   IO_L1P_3   NC
M3   IO_L1N_VREF_3   NC
M5   IO_L2P_3   NC
N4   IO_L2N_3   NC
R2   M3DQ14   NC
R1   M3DQ15   NC
P2   M3DQ12   NC
P1   M3DQ13   NC
N3   M3UDQS   NC
N1   M3UDQSN   NC
M2   M3DQ10   NC
M1   M3DQ11   NC
L1   M3DQ9   NC
K2   M3DQ0   NC
K1   M3DQ1   NC
J3   M3DQ2   NC
J1   M3DQ3   NC
H2   M3LDQS   NC
H1   M3LDQSN   NC
G3   M3DQ6   NC
G1   M3DQ7   NC
F2   GCLK27_M3DQ4   NC
F1   GCLK26_M3DQ5   NC
K3   GCLK25_TRDY2_M3UDM   NC
J4   GCLK24_M3LDM   NC
J6   GCLK23_M3RASN   NC
H5   GCLK22_IRDY2_M3CASN  NC
H4   GCLK21_M3A5   NC
H3   GCLK20_M3A6   NC
L4   M3A3   NC
L5   M3ODT   NC
E2   M3CLK   NC
E1   M3CLKN   NC
K5   M3A0   NC
K6   M3A1   NC
C3   M3BA0   NC
C2   M3BA1   NC
D3   M3A7   NC
D1   M3A2   NC
C1   M3WE   NC
B1   M3BA2   NC
G6   M3A10   NC
G5   M3A4   NC
B2   M3A8   NC
A2   M3A9   NC
F4   M3CKE   NC
F3   M3A12   NC
E4   M3RESET   NC
E3   M3A11   NC
F6   M3A13   NC
F5   M3A14   NC
B3   IO_L83P_3   NC
A3   IO_L83N_VREF_3   NC
C14   TCK   LVCMOS25_S_8_TB_25
C12   TDI   LVCMOS25_S_8_TB_25
A15   TMS   LVCMOS25_S_8_TB_25
E14   TDO   LVCMOS25_S_8_TB_25
P14   SUSPEND   LVCMOS25_S_8_TB_25
L11   CMPCS_B_2   NC
P13   DONE_2   LVCMOS25_S_8_TB_25
T2   PROGRAM_B_2   LVCMOS25_S_8_TB_25
A1   GND   GND
A16   GND   GND
B11   GND   GND
B7   GND   GND
D13   GND   GND
D4   GND   GND
E9   GND   GND
G15   GND   GND
G2   GND   GND
G8   GND   GND
H12   GND   GND
H7   GND   GND
H9   GND   GND
J5   GND   GND
J8   GND   GND
K7   GND   GND
K9   GND   GND
L15   GND   GND
L2   GND   GND
M8   GND   GND
N13   GND   GND
P3   GND   GND
R10   GND   GND
R6   GND   GND
T1   GND   GND
T16   GND   GND
B13   VCCO_0   POWER
B4   VCCO_0   POWER
B9   VCCO_0   POWER
D10   VCCO_0   POWER
D7   VCCO_0   POWER
E5   VCCAUX   POWER
F11   VCCAUX   POWER
F8   VCCAUX   POWER
G10   VCCAUX   POWER
H6   VCCAUX   POWER
J10   VCCAUX   POWER
L6   VCCAUX   POWER
L9   VCCAUX   POWER
G7   VCCINT   POWER
G9   VCCINT   POWER
H10   VCCINT   POWER
H8   VCCINT   POWER
J7   VCCINT   POWER
J9   VCCINT   POWER
K10   VCCINT   POWER
K8   VCCINT   POWER
D15   VCCO_1   POWER
G13   VCCO_1   POWER
J15   VCCO_1   POWER
K13   VCCO_1   POWER
N15   VCCO_1   POWER
R13   VCCO_1   POWER
N10   VCCO_2   POWER
N7   VCCO_2   POWER
R4   VCCO_2   POWER
R8   VCCO_2   POWER
D2   VCCO_3   POWER
G4   VCCO_3   POWER
J2   VCCO_3   POWER
K4   VCCO_3   POWER
N2   VCCO_3   POWER
[Package Model]   ftg256_xc6slx9
[Diff Pin]   inv_Pin   vdiff   tdelay_typ   tdelay_min   tdelay_max
[Series Pin Mapping] pin_2   model_name   function_table_group
[Define Package Model]   ftg256_xc6slx9
[Manufacturer]   Xilinx Inc.
[OEM]   Xilinx_S1
[Description]   200-pin Package
|[Number of Sections]   1
[Number of Pins]   200
[Pin Numbers]
|[Pin Name]  Net Number   Net Name   Net's All Pins
E5   | 1   VCCAUX   E5
   |F11
   |F8
   |G10
   |H6
   |J10
   |L6
   |L9
G7   | 2   VCCINT   G7
   |G9
   |H10
   |H8
   |J7
   |J9
   |K10
   |K8
B13   | 3   VCCO_0   B13
   |B4
   |B9
   |D10
   |D7
D15   | 4   VCCO_1   D15
   |G13
   |J15
   |K13
   |N15
   |R13
N10   | 5   VCCO_2   N10
   |N7
   |R4
   |R8
D2   | 6   VCCO_3   D2
   |G4
   |J2
   |K4
   |N2
L11   | 7   CMPCS_B_2   L11
P13   | 8   DONE_2   P13
P12   | 9   IO_L12N_D2_MISO3_2   P12
N12   | 10   IO_L12P_D1_MISO2_2   N12
P11   | 11   IO_L13N_D10_2   P11
N11   | 12   IO_L13P_M1_2   N11
P9   | 13   IO_L14N_D12_2   P9
N9   | 14   IO_L14P_D11_2   N9
M10   | 15   IO_L16N_VREF_2   M10
L10   | 16   IO_L16P_2   L10
E12   | 17   IO_L1N_A24_VREF_1   E12
A4   | 18   IO_L1N_IREF_VREF_0   A4
T11   | 19   IO_L1N_M0_CMPMISO_2   T11
M3   | 20   IO_L1N_VREF_3   M3
E13   | 21   IO_L1P_A25_1   E13
R11   | 22   IO_L1P_CCLK_2   R11
C4   | 23   IO_L1P_HSWAPEN_0   C4
M4   | 24   IO_L1P_VBG_3   M4
T9   | 25   IO_L23N_2   T9
R9   | 26   IO_L23P_2   R9
B16   | 27   IO_L29N_A22_M1A14_1   B16
N8   | 28   IO_L29N_GCLK2_2   N8
B15   | 29   IO_L29P_A23_M1A13_1   B15
M9   | 30   IO_L29P_GCLK3_2   M9
A5   | 31   IO_L2N_0   A5
M11   | 32   IO_L2N_CMPMOSI_2   M11
N4   | 33   IO_L2N_VTEMP_3   N4
B5   | 34   IO_L2P_0   B5
M12   | 35   IO_L2P_CMPCLK_2   M12
M5   | 36   IO_L2P_VGG_3   M5
G11   | 37   IO_L30N_A20_M1A11_1   G11
T8   | 38   IO_L30N_GCLK0_USERCCLK_2   T8
F12   | 39   IO_L30P_A21_M1RESET_1   F12
P8   | 40   IO_L30P_GCLK1_D13_2   P8
D16   | 41   IO_L31N_A18_M1A12_1   D16
M7   | 42   IO_L31N_GCLK30_D15_2   M7
D14   | 43   IO_L31P_A19_M1CKE_1   D14
P7   | 44   IO_L31P_GCLK31_D14_2   P7
F14   | 45   IO_L32N_A16_M1A9_1   F14
T7   | 46   IO_L32N_GCLK28_2   T7
R1   | 47   IO_L32N_M3DQ15_3   R1
F13   | 48   IO_L32P_A17_M1A8_1   F13
R7   | 49   IO_L32P_GCLK29_2   R7
R2   | 50   IO_L32P_M3DQ14_3   R2
A8   | 51   IO_L33N_0   A8
C16   | 52   IO_L33N_A14_M1A4_1   C16
P1   | 53   IO_L33N_M3DQ13_3   P1
B8   | 54   IO_L33P_0   B8
C15   | 55   IO_L33P_A15_M1A10_1   C15
P2   | 56   IO_L33P_M3DQ12_3   P2
E16   | 57   IO_L34N_A12_M1BA2_1   E16
A9   | 58   IO_L34N_GCLK18_0   A9
N1   | 59   IO_L34N_M3UDQSN_3   N1
E15   | 60   IO_L34P_A13_M1WE_1   E15
C9   | 61   IO_L34P_GCLK19_0   C9
N3   | 62   IO_L34P_M3UDQS_3   N3
F16   | 63   IO_L35N_A10_M1A2_1   F16
A10   | 64   IO_L35N_GCLK16_0   A10
M1   | 65   IO_L35N_M3DQ11_3   M1
F15   | 66   IO_L35P_A11_M1A7_1   F15
B10   | 67   IO_L35P_GCLK17_0   B10
M2   | 68   IO_L35P_M3DQ10_3   M2
G16   | 69   IO_L36N_A8_M1BA1_1   G16
E8   | 70   IO_L36N_GCLK14_0   E8
L1   | 71   IO_L36N_M3DQ9_3   L1
G14   | 72   IO_L36P_A9_M1BA0_1   G14
E7   | 73   IO_L36P_GCLK15_0   E7
L3   | 74   IO_L36P_M3DQ8_3   L3
H16   | 75   IO_L37N_A6_M1A1_1   H16
C10   | 76   IO_L37N_GCLK12_0   C10
K1   | 77   IO_L37N_M3DQ1_3   K1
H15   | 78   IO_L37P_A7_M1A0_1   H15
E10   | 79   IO_L37P_GCLK13_0   E10
K2   | 80   IO_L37P_M3DQ0_3   K2
H11   | 81   IO_L38N_A4_M1CLKN_1   H11
J1   | 82   IO_L38N_M3DQ3_3   J1
C8   | 83   IO_L38N_VREF_0   C8
D8   | 84   IO_L38P_0   D8
G12   | 85   IO_L38P_A5_M1CLK_1   G12
J3   | 86   IO_L38P_M3DQ2_3   J3
A11   | 87   IO_L39N_0   A11
H14   | 88   IO_L39N_M1ODT_1   H14
H1   | 89   IO_L39N_M3LDQSN_3   H1
C11   | 90   IO_L39P_0   C11
H13   | 91   IO_L39P_M1A3_1   H13
H2   | 92   IO_L39P_M3LDQS_3   H2
C5   | 93   IO_L3N_0   C5
T10   | 94   IO_L3N_MOSI_CSI_B_MISO0_2   T10
D5   | 95   IO_L3P_0   D5
P10   | 96   IO_L3P_D0_DIN_MISO_MISO1_2   P10
D9   | 97   IO_L40N_0   D9
J12   | 98   IO_L40N_GCLK10_M1A6_1   J12
G1   | 99   IO_L40N_M3DQ7_3   G1
F9   | 100   IO_L40P_0   F9
J11   | 101   IO_L40P_GCLK11_M1A5_1   J11
G3   | 102   IO_L40P_M3DQ6_3   G3
F1   | 103   IO_L41N_GCLK26_M3DQ5_3   F1
K14   | 104   IO_L41N_GCLK8_M1CASN_1   K14
F2   | 105   IO_L41P_GCLK27_M3DQ4_3   F2
J13   | 106   IO_L41P_GCLK9_IRDY1_M1RASN_1   J13
J4   | 107   IO_L42N_GCLK24_M3LDM_3   J4
K11   | 108   IO_L42N_GCLK6_TRDY1_M1LDM_1   K11
K3   | 109   IO_L42P_GCLK25_TRDY2_M3UDM_3   K3
K12   | 110   IO_L42P_GCLK7_M1UDM_1   K12
H5   | 111   IO_L43N_GCLK22_IRDY2_M3CASN_3   H5
J16   | 112   IO_L43N_GCLK4_M1DQ5_1   J16
J6   | 113   IO_L43P_GCLK23_M3RASN_3   J6
J14   | 114   IO_L43P_GCLK5_M1DQ4_1   J14
K16   | 115   IO_L44N_A2_M1DQ7_1   K16
H3   | 116   IO_L44N_GCLK20_M3A6_3   H3
K15   | 117   IO_L44P_A3_M1DQ6_1   K15
H4   | 118   IO_L44P_GCLK21_M3A5_3   H4
N16   | 119   IO_L45N_A0_M1LDQSN_1   N16
L5   | 120   IO_L45N_M3ODT_3   L5
N14   | 121   IO_L45P_A1_M1LDQS_1   N14
L4   | 122   IO_L45P_M3A3_3   L4
M16   | 123   IO_L46N_FOE_B_M1DQ3_1   M16
E1   | 124   IO_L46N_M3CLKN_3   E1
M15   | 125   IO_L46P_FCS_B_M1DQ2_1   M15
E2   | 126   IO_L46P_M3CLK_3   E2
T6   | 127   IO_L47N_2   T6
L16   | 128   IO_L47N_LDC_M1DQ1_1   L16
K6   | 129   IO_L47N_M3A1_3   K6
P6   | 130   IO_L47P_2   P6
L14   | 131   IO_L47P_FWE_B_M1DQ0_1   L14
K5   | 132   IO_L47P_M3A0_3   K5
P16   | 133   IO_L48N_M1DQ9_1   P16
C2   | 134   IO_L48N_M3BA1_3   C2
T5   | 135   IO_L48N_RDWR_B_VREF_2   T5
R5   | 136   IO_L48P_D7_2   R5
P15   | 137   IO_L48P_HDC_M1DQ8_1   P15
C3   | 138   IO_L48P_M3BA0_3   C3
P5   | 139   IO_L49N_D4_2   P5
R16   | 140   IO_L49N_M1DQ11_1   R16
D1   | 141   IO_L49N_M3A2_3   D1
N5   | 142   IO_L49P_D3_2   N5
R15   | 143   IO_L49P_M1DQ10_1   R15
D3   | 144   IO_L49P_M3A7_3   D3
A6   | 145   IO_L4N_0   A6
B6   | 146   IO_L4P_0   B6
T15   | 147   IO_L50N_M1UDQSN_1   T15
B1   | 148   IO_L50N_M3BA2_3   B1
R14   | 149   IO_L50P_M1UDQS_1   R14
C1   | 150   IO_L50P_M3WE_3   C1
T13   | 151   IO_L51N_M1DQ13_1   T13
G5   | 152   IO_L51N_M3A4_3   G5
T14   | 153   IO_L51P_M1DQ12_1   T14
G6   | 154   IO_L51P_M3A10_3   G6
T12   | 155   IO_L52N_M1DQ15_1   T12
A2   | 156   IO_L52N_M3A9_3   A2
R12   | 157   IO_L52P_M1DQ14_1   R12
B2   | 158   IO_L52P_M3A8_3   B2
F3   | 159   IO_L53N_M3A12_3   F3
L13   | 160   IO_L53N_VREF_1   L13
L12   | 161   IO_L53P_1   L12
F4   | 162   IO_L53P_M3CKE_3   F4
E3   | 163   IO_L54N_M3A11_3   E3
E4   | 164   IO_L54P_M3RESET_3   E4
F5   | 165   IO_L55N_M3A14_3   F5
F6   | 166   IO_L55P_M3A13_3   F6
E6   | 167   IO_L5N_0   E6
F7   | 168   IO_L5P_0   F7
L7   | 169   IO_L62N_D6_2   L7
A12   | 170   IO_L62N_VREF_0   A12
B12   | 171   IO_L62P_0   B12
L8   | 172   IO_L62P_D5_2   L8
T4   | 173   IO_L63N_2   T4
A13   | 174   IO_L63N_SCP6_0   A13
P4   | 175   IO_L63P_2   P4
C13   | 176   IO_L63P_SCP7_0   C13
N6   | 177   IO_L64N_D9_2   N6
E11   | 178   IO_L64N_SCP4_0   E11
M6   | 179   IO_L64P_D8_2   M6
F10   | 180   IO_L64P_SCP5_0   F10
T3   | 181   IO_L65N_CSO_B_2   T3
A14   | 182   IO_L65N_SCP2_0   A14
R3   | 183   IO_L65P_INIT_B_2   R3
B14   | 184   IO_L65P_SCP3_0   B14
D12   | 185   IO_L66N_SCP0_0   D12
D11   | 186   IO_L66P_SCP1_0   D11
A7   | 187   IO_L6N_0   A7
C7   | 188   IO_L6P_0   C7
M14   | 189   IO_L74N_DOUT_BUSY_1   M14
M13   | 190   IO_L74P_AWAKE_1   M13
C6   | 191   IO_L7N_0   C6
D6   | 192   IO_L7P_0   D6
A3   | 193   IO_L83N_VREF_3   A3
B3   | 194   IO_L83P_3   B3
T2   | 195   PROGRAM_B_2   T2
P14   | 196   SUSPEND   P14
C14   | 197   TCK   C14
C12   | 198   TDI   C12
E14   | 199   TDO   E14
A15   | 200   TMS   A15
[Model Data]
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[End Model Data]
[End Package Model]
| Models and submodels in the file (3): LVCMOS25_S_8_TB_25 (I/O), LVCMOS33_S_12_LR_25 (I/O), LVCMOS33_S_12_TB_25 (I/O)
